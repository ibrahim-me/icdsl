* reference netlist written by icl canvas for shreg16 (sky130A)
.subckt dff VSS VDD Q CK D
XMn0_0 VSS CK CKB VSS sky130_fd_pr__nfet_01v8 w=0.42 l=0.15
XMn0_1 n1 D VSS VSS sky130_fd_pr__nfet_01v8 w=0.42 l=0.15
XMn0_2 m CKB n1 VSS sky130_fd_pr__nfet_01v8 w=0.42 l=0.15
XMn0_3 n2 CK m VSS sky130_fd_pr__nfet_01v8 w=0.42 l=0.15
XMn0_4 VSS mb n2 VSS sky130_fd_pr__nfet_01v8 w=0.42 l=0.15
XMn0_5 mb m VSS VSS sky130_fd_pr__nfet_01v8 w=0.42 l=0.15
XMn7_0 n3 Q VSS VSS sky130_fd_pr__nfet_01v8 w=0.42 l=0.15
XMn7_1 s CKB n3 VSS sky130_fd_pr__nfet_01v8 w=0.42 l=0.15
XMn7_2 n4 CK s VSS sky130_fd_pr__nfet_01v8 w=0.42 l=0.15
XMn7_3 VSS mb n4 VSS sky130_fd_pr__nfet_01v8 w=0.42 l=0.15
XMn7_4 Q s VSS VSS sky130_fd_pr__nfet_01v8 w=0.42 l=0.15
XMp0_0 VDD CK CKB VDD sky130_fd_pr__pfet_01v8 w=0.84 l=0.15
XMp0_1 p1 D VDD VDD sky130_fd_pr__pfet_01v8 w=0.84 l=0.15
XMp0_2 m CK p1 VDD sky130_fd_pr__pfet_01v8 w=0.84 l=0.15
XMp0_3 p2 CKB m VDD sky130_fd_pr__pfet_01v8 w=0.84 l=0.15
XMp0_4 VDD mb p2 VDD sky130_fd_pr__pfet_01v8 w=0.84 l=0.15
XMp0_5 mb m VDD VDD sky130_fd_pr__pfet_01v8 w=0.84 l=0.15
XMp7_0 p3 Q VDD VDD sky130_fd_pr__pfet_01v8 w=0.84 l=0.15
XMp7_1 s CK p3 VDD sky130_fd_pr__pfet_01v8 w=0.84 l=0.15
XMp7_2 p4 CKB s VDD sky130_fd_pr__pfet_01v8 w=0.84 l=0.15
XMp7_3 VDD mb p4 VDD sky130_fd_pr__pfet_01v8 w=0.84 l=0.15
XMp7_4 Q s VDD VDD sky130_fd_pr__pfet_01v8 w=0.84 l=0.15
.ends

.subckt shreg16 VSS VDD D Q11 Q15 Q3 Q7 Q0 Q1 Q10 Q12 Q13 Q14 Q2 Q4 Q5 Q6 Q8 Q9 CK
XFF0 VSS VDD Q0 CK D dff
XFF1 VSS VDD Q1 CK Q0 dff
XFF2 VSS VDD Q2 CK Q1 dff
XFF3 VSS VDD Q3 CK Q2 dff
XFF7 VSS VDD Q7 CK Q6 dff
XFF6 VSS VDD Q6 CK Q5 dff
XFF5 VSS VDD Q5 CK Q4 dff
XFF4 VSS VDD Q4 CK Q3 dff
XFF8 VSS VDD Q8 CK Q7 dff
XFF9 VSS VDD Q9 CK Q8 dff
XFF10 VSS VDD Q10 CK Q9 dff
XFF11 VSS VDD Q11 CK Q10 dff
XFF15 VSS VDD Q15 CK Q14 dff
XFF14 VSS VDD Q14 CK Q13 dff
XFF13 VSS VDD Q13 CK Q12 dff
XFF12 VSS VDD Q12 CK Q11 dff
.ends
.end
