* reference netlist written by icl canvas for shreg16 (freepdk45)
.subckt dff VSS VDD Q CK D
Mn0_0 VSS CK CKB VSS nmos w=0.09u l=0.05u
Mn0_1 n1 D VSS VSS nmos w=0.09u l=0.05u
Mn0_2 m CKB n1 VSS nmos w=0.09u l=0.05u
Mn0_3 n2 CK m VSS nmos w=0.09u l=0.05u
Mn0_4 VSS mb n2 VSS nmos w=0.09u l=0.05u
Mn0_5 mb m VSS VSS nmos w=0.09u l=0.05u
Mn7_0 n3 Q VSS VSS nmos w=0.09u l=0.05u
Mn7_1 s CKB n3 VSS nmos w=0.09u l=0.05u
Mn7_2 n4 CK s VSS nmos w=0.09u l=0.05u
Mn7_3 VSS mb n4 VSS nmos w=0.09u l=0.05u
Mn7_4 Q s VSS VSS nmos w=0.09u l=0.05u
Mp0_0 VDD CK CKB VDD pmos w=0.18u l=0.05u
Mp0_1 p1 D VDD VDD pmos w=0.18u l=0.05u
Mp0_2 m CK p1 VDD pmos w=0.18u l=0.05u
Mp0_3 p2 CKB m VDD pmos w=0.18u l=0.05u
Mp0_4 VDD mb p2 VDD pmos w=0.18u l=0.05u
Mp0_5 mb m VDD VDD pmos w=0.18u l=0.05u
Mp7_0 p3 Q VDD VDD pmos w=0.18u l=0.05u
Mp7_1 s CK p3 VDD pmos w=0.18u l=0.05u
Mp7_2 p4 CKB s VDD pmos w=0.18u l=0.05u
Mp7_3 VDD mb p4 VDD pmos w=0.18u l=0.05u
Mp7_4 Q s VDD VDD pmos w=0.18u l=0.05u
.ends

.subckt shreg16 VSS VDD D Q11 Q15 Q3 Q7 Q0 Q1 Q10 Q12 Q13 Q14 Q2 Q4 Q5 Q6 Q8 Q9 CK
XFF0 VSS VDD Q0 CK D dff
XFF1 VSS VDD Q1 CK Q0 dff
XFF2 VSS VDD Q2 CK Q1 dff
XFF3 VSS VDD Q3 CK Q2 dff
XFF7 VSS VDD Q7 CK Q6 dff
XFF6 VSS VDD Q6 CK Q5 dff
XFF5 VSS VDD Q5 CK Q4 dff
XFF4 VSS VDD Q4 CK Q3 dff
XFF8 VSS VDD Q8 CK Q7 dff
XFF9 VSS VDD Q9 CK Q8 dff
XFF10 VSS VDD Q10 CK Q9 dff
XFF11 VSS VDD Q11 CK Q10 dff
XFF15 VSS VDD Q15 CK Q14 dff
XFF14 VSS VDD Q14 CK Q13 dff
XFF13 VSS VDD Q13 CK Q12 dff
XFF12 VSS VDD Q12 CK Q11 dff
.ends
.end
