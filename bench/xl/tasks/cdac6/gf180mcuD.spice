* reference netlist written by icl canvas for cdac6 (gf180mcuD)
.subckt cdac6 TOP B0 B1 B2 B3 VSS B4 B5
XC0 TOP VSS cap_mim_2f0_m4m5_noshield c_width=5u c_length=5u
XC1 TOP B5 cap_mim_2f0_m4m5_noshield c_width=5u c_length=5u
XC2 TOP B4 cap_mim_2f0_m4m5_noshield c_width=5u c_length=5u
XC3 TOP B5 cap_mim_2f0_m4m5_noshield c_width=5u c_length=5u
XC4 TOP B3 cap_mim_2f0_m4m5_noshield c_width=5u c_length=5u
XC5 TOP B5 cap_mim_2f0_m4m5_noshield c_width=5u c_length=5u
XC6 TOP B4 cap_mim_2f0_m4m5_noshield c_width=5u c_length=5u
XC7 TOP B5 cap_mim_2f0_m4m5_noshield c_width=5u c_length=5u
XC8 TOP B2 cap_mim_2f0_m4m5_noshield c_width=5u c_length=5u
XC9 TOP B5 cap_mim_2f0_m4m5_noshield c_width=5u c_length=5u
XC10 TOP B4 cap_mim_2f0_m4m5_noshield c_width=5u c_length=5u
XC11 TOP B5 cap_mim_2f0_m4m5_noshield c_width=5u c_length=5u
XC12 TOP B3 cap_mim_2f0_m4m5_noshield c_width=5u c_length=5u
XC13 TOP B5 cap_mim_2f0_m4m5_noshield c_width=5u c_length=5u
XC14 TOP B4 cap_mim_2f0_m4m5_noshield c_width=5u c_length=5u
XC15 TOP B5 cap_mim_2f0_m4m5_noshield c_width=5u c_length=5u
XC16 TOP B1 cap_mim_2f0_m4m5_noshield c_width=5u c_length=5u
XC17 TOP B5 cap_mim_2f0_m4m5_noshield c_width=5u c_length=5u
XC18 TOP B4 cap_mim_2f0_m4m5_noshield c_width=5u c_length=5u
XC19 TOP B5 cap_mim_2f0_m4m5_noshield c_width=5u c_length=5u
XC20 TOP B3 cap_mim_2f0_m4m5_noshield c_width=5u c_length=5u
XC21 TOP B5 cap_mim_2f0_m4m5_noshield c_width=5u c_length=5u
XC22 TOP B4 cap_mim_2f0_m4m5_noshield c_width=5u c_length=5u
XC23 TOP B5 cap_mim_2f0_m4m5_noshield c_width=5u c_length=5u
XC24 TOP B2 cap_mim_2f0_m4m5_noshield c_width=5u c_length=5u
XC25 TOP B5 cap_mim_2f0_m4m5_noshield c_width=5u c_length=5u
XC26 TOP B4 cap_mim_2f0_m4m5_noshield c_width=5u c_length=5u
XC27 TOP B5 cap_mim_2f0_m4m5_noshield c_width=5u c_length=5u
XC28 TOP B3 cap_mim_2f0_m4m5_noshield c_width=5u c_length=5u
XC29 TOP B5 cap_mim_2f0_m4m5_noshield c_width=5u c_length=5u
XC30 TOP B4 cap_mim_2f0_m4m5_noshield c_width=5u c_length=5u
XC31 TOP B5 cap_mim_2f0_m4m5_noshield c_width=5u c_length=5u
XC32 TOP B0 cap_mim_2f0_m4m5_noshield c_width=5u c_length=5u
XC33 TOP B5 cap_mim_2f0_m4m5_noshield c_width=5u c_length=5u
XC34 TOP B4 cap_mim_2f0_m4m5_noshield c_width=5u c_length=5u
XC35 TOP B5 cap_mim_2f0_m4m5_noshield c_width=5u c_length=5u
XC36 TOP B3 cap_mim_2f0_m4m5_noshield c_width=5u c_length=5u
XC37 TOP B5 cap_mim_2f0_m4m5_noshield c_width=5u c_length=5u
XC38 TOP B4 cap_mim_2f0_m4m5_noshield c_width=5u c_length=5u
XC39 TOP B5 cap_mim_2f0_m4m5_noshield c_width=5u c_length=5u
XC40 TOP B2 cap_mim_2f0_m4m5_noshield c_width=5u c_length=5u
XC41 TOP B5 cap_mim_2f0_m4m5_noshield c_width=5u c_length=5u
XC42 TOP B4 cap_mim_2f0_m4m5_noshield c_width=5u c_length=5u
XC43 TOP B5 cap_mim_2f0_m4m5_noshield c_width=5u c_length=5u
XC44 TOP B3 cap_mim_2f0_m4m5_noshield c_width=5u c_length=5u
XC45 TOP B5 cap_mim_2f0_m4m5_noshield c_width=5u c_length=5u
XC46 TOP B4 cap_mim_2f0_m4m5_noshield c_width=5u c_length=5u
XC47 TOP B5 cap_mim_2f0_m4m5_noshield c_width=5u c_length=5u
XC48 TOP B1 cap_mim_2f0_m4m5_noshield c_width=5u c_length=5u
XC49 TOP B5 cap_mim_2f0_m4m5_noshield c_width=5u c_length=5u
XC50 TOP B4 cap_mim_2f0_m4m5_noshield c_width=5u c_length=5u
XC51 TOP B5 cap_mim_2f0_m4m5_noshield c_width=5u c_length=5u
XC52 TOP B3 cap_mim_2f0_m4m5_noshield c_width=5u c_length=5u
XC53 TOP B5 cap_mim_2f0_m4m5_noshield c_width=5u c_length=5u
XC54 TOP B4 cap_mim_2f0_m4m5_noshield c_width=5u c_length=5u
XC55 TOP B5 cap_mim_2f0_m4m5_noshield c_width=5u c_length=5u
XC56 TOP B2 cap_mim_2f0_m4m5_noshield c_width=5u c_length=5u
XC57 TOP B5 cap_mim_2f0_m4m5_noshield c_width=5u c_length=5u
XC58 TOP B4 cap_mim_2f0_m4m5_noshield c_width=5u c_length=5u
XC59 TOP B5 cap_mim_2f0_m4m5_noshield c_width=5u c_length=5u
XC60 TOP B3 cap_mim_2f0_m4m5_noshield c_width=5u c_length=5u
XC61 TOP B5 cap_mim_2f0_m4m5_noshield c_width=5u c_length=5u
XC62 TOP B4 cap_mim_2f0_m4m5_noshield c_width=5u c_length=5u
XC63 TOP B5 cap_mim_2f0_m4m5_noshield c_width=5u c_length=5u
.ends
.end
