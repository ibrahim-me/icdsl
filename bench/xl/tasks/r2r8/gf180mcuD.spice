* reference netlist written by icl canvas for r2r8 (gf180mcuD)
.subckt r2r8 B0 B1 B2 B3 B4 B5 B6 B7 OUT VSS
XRT1 VSS t VSS ppolyf_u r_width=1u r_length=6u
XRT2 n0 t VSS ppolyf_u r_width=1u r_length=6u
XRA0 n0 x0 VSS ppolyf_u r_width=1u r_length=6u
XRB0 B0 x0 VSS ppolyf_u r_width=1u r_length=6u
XRS0 n0 n1 VSS ppolyf_u r_width=1u r_length=6u
XRA1 n1 x1 VSS ppolyf_u r_width=1u r_length=6u
XRB1 B1 x1 VSS ppolyf_u r_width=1u r_length=6u
XRS1 n1 n2 VSS ppolyf_u r_width=1u r_length=6u
XRA2 n2 x2 VSS ppolyf_u r_width=1u r_length=6u
XRB2 B2 x2 VSS ppolyf_u r_width=1u r_length=6u
XRS2 n2 n3 VSS ppolyf_u r_width=1u r_length=6u
XRA3 n3 x3 VSS ppolyf_u r_width=1u r_length=6u
XRB3 B3 x3 VSS ppolyf_u r_width=1u r_length=6u
XRS3 n3 n4 VSS ppolyf_u r_width=1u r_length=6u
XRA4 n4 x4 VSS ppolyf_u r_width=1u r_length=6u
XRB4 B4 x4 VSS ppolyf_u r_width=1u r_length=6u
XRS4 n4 n5 VSS ppolyf_u r_width=1u r_length=6u
XRA5 n5 x5 VSS ppolyf_u r_width=1u r_length=6u
XRB5 B5 x5 VSS ppolyf_u r_width=1u r_length=6u
XRS5 n5 n6 VSS ppolyf_u r_width=1u r_length=6u
XRA6 n6 x6 VSS ppolyf_u r_width=1u r_length=6u
XRB6 B6 x6 VSS ppolyf_u r_width=1u r_length=6u
XRS6 n6 OUT VSS ppolyf_u r_width=1u r_length=6u
XRA7 OUT x7 VSS ppolyf_u r_width=1u r_length=6u
XRB7 B7 x7 VSS ppolyf_u r_width=1u r_length=6u
.ends
.end
