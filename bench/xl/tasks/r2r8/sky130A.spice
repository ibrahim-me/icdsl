* reference netlist written by icl canvas for r2r8 (sky130A)
.subckt r2r8 B0 B1 B2 B3 B4 B5 B6 B7 OUT VSS
XRT1 VSS t sky130_fd_pr__res_generic_po w=1 l=6
XRT2 n0 t sky130_fd_pr__res_generic_po w=1 l=6
XRA0 n0 x0 sky130_fd_pr__res_generic_po w=1 l=6
XRB0 B0 x0 sky130_fd_pr__res_generic_po w=1 l=6
XRS0 n0 n1 sky130_fd_pr__res_generic_po w=1 l=6
XRA1 n1 x1 sky130_fd_pr__res_generic_po w=1 l=6
XRB1 B1 x1 sky130_fd_pr__res_generic_po w=1 l=6
XRS1 n1 n2 sky130_fd_pr__res_generic_po w=1 l=6
XRA2 n2 x2 sky130_fd_pr__res_generic_po w=1 l=6
XRB2 B2 x2 sky130_fd_pr__res_generic_po w=1 l=6
XRS2 n2 n3 sky130_fd_pr__res_generic_po w=1 l=6
XRA3 n3 x3 sky130_fd_pr__res_generic_po w=1 l=6
XRB3 B3 x3 sky130_fd_pr__res_generic_po w=1 l=6
XRS3 n3 n4 sky130_fd_pr__res_generic_po w=1 l=6
XRA4 n4 x4 sky130_fd_pr__res_generic_po w=1 l=6
XRB4 B4 x4 sky130_fd_pr__res_generic_po w=1 l=6
XRS4 n4 n5 sky130_fd_pr__res_generic_po w=1 l=6
XRA5 n5 x5 sky130_fd_pr__res_generic_po w=1 l=6
XRB5 B5 x5 sky130_fd_pr__res_generic_po w=1 l=6
XRS5 n5 n6 sky130_fd_pr__res_generic_po w=1 l=6
XRA6 n6 x6 sky130_fd_pr__res_generic_po w=1 l=6
XRB6 B6 x6 sky130_fd_pr__res_generic_po w=1 l=6
XRS6 n6 OUT sky130_fd_pr__res_generic_po w=1 l=6
XRA7 OUT x7 sky130_fd_pr__res_generic_po w=1 l=6
XRB7 B7 x7 sky130_fd_pr__res_generic_po w=1 l=6
.ends
.end
