* reference netlist written by icl canvas for sram16x8 (sky130A)
.subckt sram6t VSS VDD BL BLB WL
XMn0_0 Q WL BL VSS sky130_fd_pr__nfet_01v8 w=0.42 l=0.15
XMn0_1 VSS QB Q VSS sky130_fd_pr__nfet_01v8 w=0.42 l=0.15
XMn0_2 QB Q VSS VSS sky130_fd_pr__nfet_01v8 w=0.42 l=0.15
XMn0_3 BLB WL QB VSS sky130_fd_pr__nfet_01v8 w=0.42 l=0.15
XMp1_0 VDD QB Q VDD sky130_fd_pr__pfet_01v8 w=0.84 l=0.15
XMp1_1 QB Q VDD VDD sky130_fd_pr__pfet_01v8 w=0.84 l=0.15
.ends

.subckt sram16x8 VSS VDD BL0 BL1 BL2 BL3 BL4 BL5 BL6 BL7 BLB0 BLB1 BLB2 BLB3 BLB4 BLB5 BLB6 BLB7 WL0 WL1 WL10 WL11 WL12 WL13 WL14 WL15 WL2 WL3 WL4 WL5 WL6 WL7 WL8 WL9
XB0_0 VSS VDD BL0 BLB0 WL0 sram6t
XB0_1 VSS VDD BL1 BLB1 WL0 sram6t
XB0_2 VSS VDD BL2 BLB2 WL0 sram6t
XB0_3 VSS VDD BL3 BLB3 WL0 sram6t
XB0_4 VSS VDD BL4 BLB4 WL0 sram6t
XB0_5 VSS VDD BL5 BLB5 WL0 sram6t
XB0_6 VSS VDD BL6 BLB6 WL0 sram6t
XB0_7 VSS VDD BL7 BLB7 WL0 sram6t
XB1_0 VSS VDD BL0 BLB0 WL1 sram6t
XB1_1 VSS VDD BL1 BLB1 WL1 sram6t
XB1_2 VSS VDD BL2 BLB2 WL1 sram6t
XB1_3 VSS VDD BL3 BLB3 WL1 sram6t
XB1_4 VSS VDD BL4 BLB4 WL1 sram6t
XB1_5 VSS VDD BL5 BLB5 WL1 sram6t
XB1_6 VSS VDD BL6 BLB6 WL1 sram6t
XB1_7 VSS VDD BL7 BLB7 WL1 sram6t
XB2_0 VSS VDD BL0 BLB0 WL2 sram6t
XB2_1 VSS VDD BL1 BLB1 WL2 sram6t
XB2_2 VSS VDD BL2 BLB2 WL2 sram6t
XB2_3 VSS VDD BL3 BLB3 WL2 sram6t
XB2_4 VSS VDD BL4 BLB4 WL2 sram6t
XB2_5 VSS VDD BL5 BLB5 WL2 sram6t
XB2_6 VSS VDD BL6 BLB6 WL2 sram6t
XB2_7 VSS VDD BL7 BLB7 WL2 sram6t
XB3_0 VSS VDD BL0 BLB0 WL3 sram6t
XB3_1 VSS VDD BL1 BLB1 WL3 sram6t
XB3_2 VSS VDD BL2 BLB2 WL3 sram6t
XB3_3 VSS VDD BL3 BLB3 WL3 sram6t
XB3_4 VSS VDD BL4 BLB4 WL3 sram6t
XB3_5 VSS VDD BL5 BLB5 WL3 sram6t
XB3_6 VSS VDD BL6 BLB6 WL3 sram6t
XB3_7 VSS VDD BL7 BLB7 WL3 sram6t
XB4_0 VSS VDD BL0 BLB0 WL4 sram6t
XB4_1 VSS VDD BL1 BLB1 WL4 sram6t
XB4_2 VSS VDD BL2 BLB2 WL4 sram6t
XB4_3 VSS VDD BL3 BLB3 WL4 sram6t
XB4_4 VSS VDD BL4 BLB4 WL4 sram6t
XB4_5 VSS VDD BL5 BLB5 WL4 sram6t
XB4_6 VSS VDD BL6 BLB6 WL4 sram6t
XB4_7 VSS VDD BL7 BLB7 WL4 sram6t
XB5_0 VSS VDD BL0 BLB0 WL5 sram6t
XB5_1 VSS VDD BL1 BLB1 WL5 sram6t
XB5_2 VSS VDD BL2 BLB2 WL5 sram6t
XB5_3 VSS VDD BL3 BLB3 WL5 sram6t
XB5_4 VSS VDD BL4 BLB4 WL5 sram6t
XB5_5 VSS VDD BL5 BLB5 WL5 sram6t
XB5_6 VSS VDD BL6 BLB6 WL5 sram6t
XB5_7 VSS VDD BL7 BLB7 WL5 sram6t
XB6_0 VSS VDD BL0 BLB0 WL6 sram6t
XB6_1 VSS VDD BL1 BLB1 WL6 sram6t
XB6_2 VSS VDD BL2 BLB2 WL6 sram6t
XB6_3 VSS VDD BL3 BLB3 WL6 sram6t
XB6_4 VSS VDD BL4 BLB4 WL6 sram6t
XB6_5 VSS VDD BL5 BLB5 WL6 sram6t
XB6_6 VSS VDD BL6 BLB6 WL6 sram6t
XB6_7 VSS VDD BL7 BLB7 WL6 sram6t
XB7_0 VSS VDD BL0 BLB0 WL7 sram6t
XB7_1 VSS VDD BL1 BLB1 WL7 sram6t
XB7_2 VSS VDD BL2 BLB2 WL7 sram6t
XB7_3 VSS VDD BL3 BLB3 WL7 sram6t
XB7_4 VSS VDD BL4 BLB4 WL7 sram6t
XB7_5 VSS VDD BL5 BLB5 WL7 sram6t
XB7_6 VSS VDD BL6 BLB6 WL7 sram6t
XB7_7 VSS VDD BL7 BLB7 WL7 sram6t
XB8_0 VSS VDD BL0 BLB0 WL8 sram6t
XB8_1 VSS VDD BL1 BLB1 WL8 sram6t
XB8_2 VSS VDD BL2 BLB2 WL8 sram6t
XB8_3 VSS VDD BL3 BLB3 WL8 sram6t
XB8_4 VSS VDD BL4 BLB4 WL8 sram6t
XB8_5 VSS VDD BL5 BLB5 WL8 sram6t
XB8_6 VSS VDD BL6 BLB6 WL8 sram6t
XB8_7 VSS VDD BL7 BLB7 WL8 sram6t
XB9_0 VSS VDD BL0 BLB0 WL9 sram6t
XB9_1 VSS VDD BL1 BLB1 WL9 sram6t
XB9_2 VSS VDD BL2 BLB2 WL9 sram6t
XB9_3 VSS VDD BL3 BLB3 WL9 sram6t
XB9_4 VSS VDD BL4 BLB4 WL9 sram6t
XB9_5 VSS VDD BL5 BLB5 WL9 sram6t
XB9_6 VSS VDD BL6 BLB6 WL9 sram6t
XB9_7 VSS VDD BL7 BLB7 WL9 sram6t
XB10_0 VSS VDD BL0 BLB0 WL10 sram6t
XB10_1 VSS VDD BL1 BLB1 WL10 sram6t
XB10_2 VSS VDD BL2 BLB2 WL10 sram6t
XB10_3 VSS VDD BL3 BLB3 WL10 sram6t
XB10_4 VSS VDD BL4 BLB4 WL10 sram6t
XB10_5 VSS VDD BL5 BLB5 WL10 sram6t
XB10_6 VSS VDD BL6 BLB6 WL10 sram6t
XB10_7 VSS VDD BL7 BLB7 WL10 sram6t
XB11_0 VSS VDD BL0 BLB0 WL11 sram6t
XB11_1 VSS VDD BL1 BLB1 WL11 sram6t
XB11_2 VSS VDD BL2 BLB2 WL11 sram6t
XB11_3 VSS VDD BL3 BLB3 WL11 sram6t
XB11_4 VSS VDD BL4 BLB4 WL11 sram6t
XB11_5 VSS VDD BL5 BLB5 WL11 sram6t
XB11_6 VSS VDD BL6 BLB6 WL11 sram6t
XB11_7 VSS VDD BL7 BLB7 WL11 sram6t
XB12_0 VSS VDD BL0 BLB0 WL12 sram6t
XB12_1 VSS VDD BL1 BLB1 WL12 sram6t
XB12_2 VSS VDD BL2 BLB2 WL12 sram6t
XB12_3 VSS VDD BL3 BLB3 WL12 sram6t
XB12_4 VSS VDD BL4 BLB4 WL12 sram6t
XB12_5 VSS VDD BL5 BLB5 WL12 sram6t
XB12_6 VSS VDD BL6 BLB6 WL12 sram6t
XB12_7 VSS VDD BL7 BLB7 WL12 sram6t
XB13_0 VSS VDD BL0 BLB0 WL13 sram6t
XB13_1 VSS VDD BL1 BLB1 WL13 sram6t
XB13_2 VSS VDD BL2 BLB2 WL13 sram6t
XB13_3 VSS VDD BL3 BLB3 WL13 sram6t
XB13_4 VSS VDD BL4 BLB4 WL13 sram6t
XB13_5 VSS VDD BL5 BLB5 WL13 sram6t
XB13_6 VSS VDD BL6 BLB6 WL13 sram6t
XB13_7 VSS VDD BL7 BLB7 WL13 sram6t
XB14_0 VSS VDD BL0 BLB0 WL14 sram6t
XB14_1 VSS VDD BL1 BLB1 WL14 sram6t
XB14_2 VSS VDD BL2 BLB2 WL14 sram6t
XB14_3 VSS VDD BL3 BLB3 WL14 sram6t
XB14_4 VSS VDD BL4 BLB4 WL14 sram6t
XB14_5 VSS VDD BL5 BLB5 WL14 sram6t
XB14_6 VSS VDD BL6 BLB6 WL14 sram6t
XB14_7 VSS VDD BL7 BLB7 WL14 sram6t
XB15_0 VSS VDD BL0 BLB0 WL15 sram6t
XB15_1 VSS VDD BL1 BLB1 WL15 sram6t
XB15_2 VSS VDD BL2 BLB2 WL15 sram6t
XB15_3 VSS VDD BL3 BLB3 WL15 sram6t
XB15_4 VSS VDD BL4 BLB4 WL15 sram6t
XB15_5 VSS VDD BL5 BLB5 WL15 sram6t
XB15_6 VSS VDD BL6 BLB6 WL15 sram6t
XB15_7 VSS VDD BL7 BLB7 WL15 sram6t
.ends
.end
