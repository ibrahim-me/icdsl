* reference netlist written by icl canvas for rca8 (freepdk45)
.subckt fa VSS VDD COUT SUM A B CIN
Mn0_0 VSS A n1 VSS nmos w=0.09u l=0.05u
Mn0_1 n1 B VSS VSS nmos w=0.09u l=0.05u
Mn0_2 CB CIN n1 VSS nmos w=0.09u l=0.05u
Mn0_3 n2 B CB VSS nmos w=0.09u l=0.05u
Mn0_4 VSS A n2 VSS nmos w=0.09u l=0.05u
Mn0_5 n3 A VSS VSS nmos w=0.09u l=0.05u
Mn0_6 VSS B n3 VSS nmos w=0.09u l=0.05u
Mn0_7 n3 CIN VSS VSS nmos w=0.09u l=0.05u
Mn0_8 SB CB n3 VSS nmos w=0.09u l=0.05u
Mn0_9 n5 CIN SB VSS nmos w=0.09u l=0.05u
Mn0_10 n4 B n5 VSS nmos w=0.09u l=0.05u
Mn0_11 VSS A n4 VSS nmos w=0.09u l=0.05u
Mn0_12 COUT CB VSS VSS nmos w=0.09u l=0.05u
Mn14 VSS SB SUM VSS nmos w=0.09u l=0.05u
Mp0_0 VDD A p1 VDD pmos w=0.18u l=0.05u
Mp0_1 p1 B VDD VDD pmos w=0.18u l=0.05u
Mp0_2 CB CIN p1 VDD pmos w=0.18u l=0.05u
Mp0_3 p2 B CB VDD pmos w=0.18u l=0.05u
Mp0_4 VDD A p2 VDD pmos w=0.18u l=0.05u
Mp0_5 p3 A VDD VDD pmos w=0.18u l=0.05u
Mp0_6 VDD B p3 VDD pmos w=0.18u l=0.05u
Mp0_7 p3 CIN VDD VDD pmos w=0.18u l=0.05u
Mp0_8 SB CB p3 VDD pmos w=0.18u l=0.05u
Mp0_9 p5 CIN SB VDD pmos w=0.18u l=0.05u
Mp0_10 p4 B p5 VDD pmos w=0.18u l=0.05u
Mp0_11 VDD A p4 VDD pmos w=0.18u l=0.05u
Mp0_12 COUT CB VDD VDD pmos w=0.18u l=0.05u
Mp14 VDD SB SUM VDD pmos w=0.18u l=0.05u
.ends

.subckt rca8 VSS VDD A0 A1 A2 A3 A4 A5 A6 A7 B0 B1 B2 B3 B4 B5 B6 B7 CIN COUT S0 S1 S2 S3 S4 S5 S6 S7
XFA0 VSS VDD k1 S0 A0 B0 CIN fa
XFA1 VSS VDD k2 S1 A1 B1 k1 fa
XFA2 VSS VDD k3 S2 A2 B2 k2 fa
XFA3 VSS VDD k4 S3 A3 B3 k3 fa
XFA7 VSS VDD COUT S7 A7 B7 k7 fa
XFA6 VSS VDD k7 S6 A6 B6 k6 fa
XFA5 VSS VDD k6 S5 A5 B5 k5 fa
XFA4 VSS VDD k5 S4 A4 B4 k4 fa
.ends
.end
