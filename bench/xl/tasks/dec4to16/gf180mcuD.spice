* reference netlist written by icl canvas for dec4to16 (gf180mcuD)
.subckt inv VSS VDD Y A
XMn0 Y A VSS VSS nfet_03v3 w=0.36u l=0.28u
XMp0 Y A VDD VDD pfet_03v3 w=0.72u l=0.28u
.ends

.subckt nand4 VSS VDD Y A B C D
XMn0_0 x1 A VSS VSS nfet_03v3 w=0.36u l=0.28u
XMn0_1 x2 B x1 VSS nfet_03v3 w=0.36u l=0.28u
XMn0_2 x3 C x2 VSS nfet_03v3 w=0.36u l=0.28u
XMn0_3 Y D x3 VSS nfet_03v3 w=0.36u l=0.28u
XMp0_0 Y A VDD VDD pfet_03v3 w=0.72u l=0.28u
XMp0_1 VDD B Y VDD pfet_03v3 w=0.72u l=0.28u
XMp0_2 Y C VDD VDD pfet_03v3 w=0.72u l=0.28u
XMp0_3 VDD D Y VDD pfet_03v3 w=0.72u l=0.28u
.ends

.subckt dec4to16 VSS VDD Y0 Y1 Y10 Y11 Y12 Y13 Y14 Y15 Y2 Y3 Y4 Y5 Y6 Y7 Y8 Y9 A0 A1 A2 A3
XIA0 VSS VDD AB0 A0 inv
XN0 VSS VDD YB0 AB0 AB1 AB2 AB3 nand4
XI0 VSS VDD Y0 YB0 inv
XN1 VSS VDD YB1 A0 AB1 AB2 AB3 nand4
XI1 VSS VDD Y1 YB1 inv
XN2 VSS VDD YB2 AB0 A1 AB2 AB3 nand4
XI2 VSS VDD Y2 YB2 inv
XN3 VSS VDD YB3 A0 A1 AB2 AB3 nand4
XI3 VSS VDD Y3 YB3 inv
XIA1 VSS VDD AB1 A1 inv
XN4 VSS VDD YB4 AB0 AB1 A2 AB3 nand4
XI4 VSS VDD Y4 YB4 inv
XN5 VSS VDD YB5 A0 AB1 A2 AB3 nand4
XI5 VSS VDD Y5 YB5 inv
XN6 VSS VDD YB6 AB0 A1 A2 AB3 nand4
XI6 VSS VDD Y6 YB6 inv
XN7 VSS VDD YB7 A0 A1 A2 AB3 nand4
XI7 VSS VDD Y7 YB7 inv
XIA2 VSS VDD AB2 A2 inv
XN8 VSS VDD YB8 AB0 AB1 AB2 A3 nand4
XI8 VSS VDD Y8 YB8 inv
XN9 VSS VDD YB9 A0 AB1 AB2 A3 nand4
XI9 VSS VDD Y9 YB9 inv
XN10 VSS VDD YB10 AB0 A1 AB2 A3 nand4
XI10 VSS VDD Y10 YB10 inv
XN11 VSS VDD YB11 A0 A1 AB2 A3 nand4
XI11 VSS VDD Y11 YB11 inv
XIA3 VSS VDD AB3 A3 inv
XN12 VSS VDD YB12 AB0 AB1 A2 A3 nand4
XI12 VSS VDD Y12 YB12 inv
XN13 VSS VDD YB13 A0 AB1 A2 A3 nand4
XI13 VSS VDD Y13 YB13 inv
XN14 VSS VDD YB14 AB0 A1 A2 A3 nand4
XI14 VSS VDD Y14 YB14 inv
XN15 VSS VDD YB15 A0 A1 A2 A3 nand4
XI15 VSS VDD Y15 YB15 inv
.ends
.end
